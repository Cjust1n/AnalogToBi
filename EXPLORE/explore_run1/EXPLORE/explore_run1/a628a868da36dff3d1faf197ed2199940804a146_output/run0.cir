* Auto-generated SPICE deck for op-amp evaluation
.param sw_stat_global=0 mc_skew=1 res_mc_skew=1 cap_mc_skew=1
.param fnoicor=0
.lib /usr/share/pdk/gf180mcuD/libs.tech/ngspice/sm141064.spice typical

.subckt CIRCUIT_Opamp VIN1 VIN2 VOUT1 VOUT2 VDD VSS VB1 VB2 VB3
M_NM2 VOUT1 VB1 NET1 VSS nfet_03v3.0 w=10u l=1u
M_PM10 VOUT1 VB2 NET2 VDD pfet_03v3.0 w=15u l=1u
M_PM7 VOUT2 VB3 VDD VDD pfet_03v3.0 w=15u l=1u
M_NM17 VOUT2 VB1 VSS VSS nfet_03v3.0 w=10u l=1u
M_NM7 NET1 VIN1 VSS VSS nfet_03v3.0 w=10u l=1u
M_PM33 NET2 VB3 VDD VDD pfet_03v3.0 w=15u l=1u
M_NM35 NET2 VIN2 NET1 VSS nfet_03v3.0 w=10u l=1u
M_NM24 0 0 VSS VSS nfet_03v3.0 w=10u l=1u
M_NM26 NET1 VB3 VSS VSS nfet_03v3.0 w=10u l=1u
.ends CIRCUIT_Opamp

* Auto-generated op-amp testbench
.param VDDVAL=1.8 VCM=0.9 VIN_LO=0.8 VIN_HI=1
.param VINP_AC=0.5 VINN_AC=-0.5 VDD_AC=0
.param STEP_AMP=0.02 TSTOP=5e-06 TR_STP=1e-09
.param STEP_DELAY=1e-06 STEP_RISE=1e-09 STEP_FALL=1e-09 STEP_WIDTH=1e-06 STEP_PERIOD=2e-06
VVDD VDD 0 {VDDVAL}
VVSS VSS 0 0
VINP VINP 0 DC {VCM} AC {VINP_AC} PULSE(0.89 0.91 {STEP_DELAY} {STEP_RISE} {STEP_FALL} {STEP_WIDTH} {STEP_PERIOD})
VINN VINN 0 DC {VCM} AC {VINN_AC}
CL VOUT 0 1e-12
RL VOUT 0 100000
VVB1 VB1 0 0.9
VVB2 VB2 0 0.9
VVB3 VB3 0 0.9

* Port order: VIN1 VIN2 VOUT1 VOUT2 VDD VSS VB1 VB2 VB3
* Connected nodes: VINP VINN VOUT VOUT2 VDD VSS VB1 VB2 VB3
XUUT VINP VINN VOUT VOUT2 VDD VSS VB1 VB2 VB3 CIRCUIT_Opamp

.control
set noaskquit
set filetype=ascii
option method=gear reltol=1e-4 abstol=1e-12 vntol=1e-6 maxord=2 gmin=1e-12 srcsteps=10 itl1=200 itl4=200

* Operating point
op
print v(vout) v(vinp) v(vinn) i(vvdd)

* DC sweep for low-frequency gain and input offset voltage
dc VINP 0.8 1 0.001
meas dc VOUT_LO find v(vout) at=0.8
meas dc VOUT_HI find v(vout) at=1
let AV = (VOUT_HI-VOUT_LO)/(1-0.8)
print VOUT_LO VOUT_HI AV
meas dc VINP_at_VCM when v(vout)=0.9
let VOS = VINP_at_VCM - 0.9
let OFFSET = VOS
print VOS OFFSET

* AC open-loop gain, GBW, and phase margin
ac dec 100 1 1e+09
meas ac AV0 find vdb(vout) at=1
meas ac UGB when vdb(vout)=0
meas ac PH_UGB find vp(vout) at=ugb
let PM = 180 + PH_UGB
print AV0 UGB PH_UGB PM

* Common-mode rejection ratio
alterparam VINP_AC=0.5 VINN_AC=0.5 VDD_AC=0
reset
ac dec 100 1 1e+09
meas ac ACMR find vdb(vout) at=1
let CMRR = AV0 - ACMR
print ACMR CMRR

* Power-supply rejection ratio
alterparam VINP_AC=0 VINN_AC=0 VDD_AC=1
reset
ac dec 100 1 1e+09
meas ac APSRR find vdb(vout) at=1
let PSRR = -APSRR
print APSRR PSRR

* Output noise
alterparam VINP_AC=0.5 VINN_AC=-0.5 VDD_AC=0
reset
noise v(vout) vinp dec 100 1 1e+09
meas noise NOISE find onoise at=1
print NOISE

* Transient measurements: settling time, slew rate, average power dissipation
tran 1e-09 5e-06
meas tran V_PRE find v(vout) at=2.50125e-07
meas tran V_POST find v(vout) at=1.901e-06
let VCM_MEAS = 0.9
let STEP_DELAY_MEAS = 1e-06
let V_STEP = V_POST - V_PRE
let V_TARGET = V_PRE + 0.5 * V_STEP
let V_LOW = V_POST - (0.0002)
let V_HIGH = V_POST + (0.0002)
meas tran T_RISE when v(vout)=V_TARGET rise=1
meas tran T_SETTLE when v(vout)=V_HIGH cross=1
meas tran SR_POS MAX deriv(v(vout)) from=1.151e-06 to=2.001e-06
meas tran SR_NEG MIN deriv(v(vout)) from=1.151e-06 to=2.001e-06
meas tran I_VDD AVG i(vvdd) from=1.151e-06 to=2.001e-06
meas tran I_INRUSH MAX abs(i(vvdd)) from=0 to=1.001e-06
let P_DISS = abs(1.8 * I_VDD)
let OFFSET_T = V_PRE - VCM_MEAS
wrdata tran_wave.dat time v(vout) i(vvdd)
print V_PRE V_POST V_STEP V_TARGET VCM_MEAS OFFSET_T T_RISE T_SETTLE I_VDD I_INRUSH P_DISS

quit
.endc

.end
